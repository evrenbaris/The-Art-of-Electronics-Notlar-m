* Voltage Divider Example
V1 in 0 DC 28
R1 in out 10k
R2 out 0 5.6k
Rload out 0 100k
.op
.end
