* RC Low-pass transient and AC
V1 in 0 PULSE(0 5 0 1u 1u 5m 10m)
R1 in out 10k
C1 out 0 100n
.tran 0 50m 0 10u
.ac dec 100 1 1Meg
.end
