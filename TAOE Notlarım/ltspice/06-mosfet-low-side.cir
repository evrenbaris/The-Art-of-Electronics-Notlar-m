* MOSFET low-side switch concept
Vcc vcc 0 DC 28
Vg gate 0 PULSE(0 10 0 50n 50n 50u 100u)
Rload vcc drain 28
M1 drain gate 0 0 NMOSGEN
.model NMOSGEN NMOS(Vto=3 Kp=5 Rs=0.02 Rd=0.02 Lambda=0.01)
.tran 0 300u 0 100n
.end
