* RC High-pass / edge coupling
V1 in 0 PULSE(0 5 0 1u 1u 5m 10m)
C1 in out 100n
R1 out 0 10k
.tran 0 50m 0 10u
.end
